/*
 * RCS Info
 * $Id: disciplines.vams,v 1.1 2006-10-30 09:31:16 raimi Exp $
 *
 * Log
 * $Log: not supported by cvs2svn $
 * Revision 1.3  2005/05/10 09:14:24  r29173
 * updated contents
 *
 *
*/

nature Current
 access=I;
 units="A";
 abstol=1e-12;
endnature

nature Voltage
 access=V;
 units="V";
 abstol=1e-6;
endnature

discipline electrical
 potential Voltage;
 flow      Current;
enddiscipline

nature Temperature
 access=Temp;
 units="C";
 abstol=1e-4;
endnature

nature Power
 access=Pwr;
 units="W";
 abstol=1e-9;
endnature

discipline thermal
 potential Temperature;
 flow      Power;
enddiscipline
