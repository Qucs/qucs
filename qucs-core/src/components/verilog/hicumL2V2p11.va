//HICUM Level_2 Version_2.1: A Verilog-A Description
//Default simulator: Spectre

//ADS
`include "constants.vams"
`include "disciplines.vams"
//`include "compact.vams"

//Spectre
//`include "constants.h"
//`include "discipline.h"

`define LN_EXP_LIMIT 	11.0
`define ICKexp_lim   	30.0
`define VPT_thresh   	1.0e2
`define Dexp_lim     	80.0
`define DFa_fj		1.921812
`define RTOLC		1.0e-5
`define l_itmax		100
`define TMAX		326.85
`define TMIN		-100.0

// DEPLETION CAPACITANCE AND CHARGE CALCULATION
// Hyperbolic smoothing used; no punch-through
// INPUT:
//  c_0		: zero-bias capacitance
//  u_d		: built-in voltage
//  z		: exponent coefficient
//  a_j		: control parameter for C peak value at high forward bias
//  U_cap	: voltage across junction
// IMPLICIT INPUT:
//  VT		: thermal voltage
// OUTPUT:
//  Qz		: depletion Charge
//  C		: depletion capacitance (Until ddx() is operative)
`define QCJMODF(c_0,u_d,z,a_j,U_cap,C,Qz)\
  if(c_0 > 0.0) begin\
      DFV_f	= u_d*(1.0-exp(-ln(a_j)/z));\
      DFC_max	= a_j*c_0;\
      DFv_e	= (DFV_f-U_cap)/VT;\
      if(DFv_e < `Dexp_lim) begin\
      		DFe	= exp(DFv_e);\
      		DFv_j	= DFV_f-VT*ln(1.0+DFe);\
      		DFdvj_dv= DFe/(1.0+DFe);\
      end else begin\
      		DFv_j	= U_cap;\
      		DFdvj_dv= 1;\
      end\
      DFb	= ln(1.0-DFv_j/u_d);\
      DFC_j1	= c_0*exp(-z*DFb)*DFdvj_dv;\
      C		= DFC_j1+DFC_max*(1.0-DFdvj_dv);\
      DFQ_j	= c_0*u_d*(1.0-exp(DFb*(1.0-z)))/(1.0-z);\
      Qz	= DFQ_j+DFC_max*(U_cap-DFv_j);\
  end else begin\
      C		= 0.0;\
      Qz	= 0.0;\
  end

// DEPLETION CAPACITANCE AND CHARGE CALCULATION
// smoothing of reverse bias region (punch-through)
// and limiting to aj=Cj,max/Cj0 for forward bias.
// Important for base-collector and collector-substrate junction
// INPUT:
//  c_0		: zero-bias capacitance
//  u_d		: built-in voltage
//  z 		: exponent coefficient
//  aj		: control parameter for C peak value at high forward bias
//  v_pt	: punch-through voltage (defined as qNw^2/2e)
//  U_cap	: voltage across junction
// IMPLICIT INPUT:
//  VT		: thermal voltage
// OUTPUT:
//  Qz		: depletion charge
//  C		: depletion capacitance (Until ddx() is operative)
`define QCJMOD(c_0,u_d,z,aj,v_pt,U_cap,C,Qz)\
   if(c_0 > 0.0) begin\
      Dz_r	= z/4.0;\
      Dv_p	= v_pt-u_d;\
      DV_f	= u_d*(1.0-exp(-ln(aj)/z));\
      DC_max	= aj*c_0;\
      DC_c	= c_0*exp(ln(v_pt/u_d)*(Dz_r-z));\
      Da	= VT;\
      Dv_e	= (DV_f-U_cap)/Da;\
      if(Dv_e < `Dexp_lim) begin\
        De	= exp(Dv_e);\
        De_1	= De/(1.0+De);\
        Dv_j1	= DV_f-Da*ln(1.0+De);\
      end else begin\
        De_1	= 1.0;\
        Dv_j1	= U_cap;\
      end\
      Da	= 0.1*Dv_p+4.0*VT;\
      Dv_r	= (Dv_p+Dv_j1)/Da;\
      if(Dv_r < `Dexp_lim) begin\
       	De	= exp(Dv_r);\
       	De_2	= De/(1.0+De);\
       	Dv_j2	= -Dv_p+Da*ln(1.0+De);\
      end else begin\
       	De_2	= 1.0;\
       	Dv_j2	= Dv_j1;\
      end\
      Dv_j4	= U_cap-Dv_j1;\
      DCln1	= ln(1.0-Dv_j1/u_d);\
      DCln2	= ln(1.0-Dv_j2/u_d);\
      Dz1	= 1.0-z;\
      Dzr1	= 1.0-Dz_r;\
      DC_j1	= c_0*exp(DCln2*(-z))*De_1*De_2;\
      DC_j2	= DC_c*exp(DCln1*(-Dz_r))*(1.0-De_2);\
      DC_j3	= DC_max*(1.0-De_1);\
      C		= DC_j1+DC_j2+DC_j3;\
      DQ_j1	= c_0*(1.0-exp(DCln2*Dz1))/Dz1;\
      DQ_j2	= DC_c*(1.0-exp(DCln1*Dzr1))/Dzr1;\
      DQ_j3	= DC_c*(1.0-exp(DCln2*Dzr1))/Dzr1;\
      Qz	= (DQ_j1+DQ_j2-DQ_j3)*u_d+DC_max*Dv_j4;\
  end else begin\
      C		= 0.0;\
      Qz	= 0.0;\
  end

// DEPLETION CAPACITANCE AND CHARGE CALCULATION SELECTOR:
// Dependent on junction punch-through voltage
// Important for collector related junctions
`define HICJCAP(c_0,u_d,z,v_pt,U_cap,C,Qz)\
	if(v_pt < `VPT_thresh) begin\
		`QCJMOD(c_0,u_d,z,2.4,v_pt,U_cap,C,Qz)\
	end else begin\
		`QCJMODF(c_0,u_d,z,2.4,U_cap,C,Qz)\
	end

// A CALCULATION NEEDED FOR COLLECTOR MINORITY CHARGE FORMULATION
// INPUT:
//  zb,zl 	: zeta_b and zeta_l (model parameters, TED 10/96)
//  w     	: normalized injection width
// OUTPUT:
// hicfcio	: function of equation (2.1.17-10)
`define HICFCI(zb,zl,lnzb,w,hicfcio,dhicfcio_dw)\
	z	= zb*w;\
      	if(z > 1.0e-6) begin\
        	x		= 1.0+z;\
        	a		= x*x;\
        	a2		= 0.250*(a*(2.0*lnzb-1.0)+1.0);\
        	a3		= (a*x*(3.0*lnzb-1.0)+1.0)/9.0;\
        	r		= zl/zb;\
        	hicfcio		= ((1.0-r)*a2+r*a3)/zb;\
        	dhicfcio_dw	= ((1.0-r)*x+r*a)*lnzb;\
      	end else begin\
        	a		= z*z;\
        	a2		= 3.0+z-0.5*a+z*a;\
        	a3		= -2.0*z+1.5*a+2.0*a*a/3.0;\
        	hicfcio		= (zb*a2+zl*a3)*w*w/6.0;\
        	dhicfcio_dw	= z+0.5*a-a*z/3.0+5.0*a*a/6.0+zl*w*(a-z+2.0*a*a/3.0);\
      	end

// NEEDED TO CALCULATE WEIGHTED ICCR COLLECTOR MINORITY CHARGE
// INPUT:
//  z : zeta_b or zeta_l
//  w : normalized injection width
// OUTPUT:
//  hicfcto   	: output
//  dhicfcto_dw : derivative of output wrt w
`define HICFCT(z,lnz,w,hicfcto,dhicfcto_dw)\
    a = z*w;\
    if (a > 1.0e-6) begin\
        hicfcto   	= (a - lnz)/z;\
        dhicfcto_dw 	= a / (1.0 + a);\
    end else begin\
        hicfcto   	= 0.5 * a * w;\
        dhicfcto_dw 	= a;\
    end\

// COLLECTOR CURRENT SPREADING CALCULATION
// collector minority charge incl. 2D/3D current spreading (TED 10/96)
// INPUT:
//  Ix   			: forward transport current component (itf)
//  I_CK			: critical current
//  FFT_pcS			: dependent on fthc and thcs (parameters)
// IMPLICIT INPUT:
//  alhc, latl, latb		: model parameters
//  VT				: thermal voltage
// OUTPUT:
//  Q_fC, Q_CT: actual and ICCR (weighted) hole charge
//  T_fC, T_cT: actual and ICCR (weighted) transit time
//  Derivative dfCT_ditf not properly implemented yet
`define HICQFC(Ix,I_CK,FFT_pcS,Q_fC,Q_CT,T_fC,T_cT)\
	Q_fC		= FFT_pcS*Ix;\
      	FCa		= 1.0-I_CK/Ix;\
      	FCrt		= sqrt(FCa*FCa+alhc);\
      	FCa_ck		= 1.0-(FCa+FCrt)/(1.0+sqrt(1.0+alhc));\
      	FCdaick_ditf	= (FCa_ck-1.0)*(1-FCa)/(FCrt*Ix);\
      	if(latb > latl) begin\
        	FCz		= latb-latl;\
        	FCxl		= 1.0+latl;\
        	FCxb		= 1.0+latb;\
        	if(latb > 0.01) begin\
        		FCln		= ln(FCxb/FCxl);\
        		FCa1		= exp((FCa_ck-1.0)*FCln);\
        		FCd_a		= 1.0/(latl-FCa1*latb);\
			FCw		= (FCa1-1.0)*FCd_a;\
        		FCa		= ln((1.0+latb*FCw)/(1.0+latl*FCw));\
        		FCdw_daick	= -FCz*FCa1*FCln*FCd_a*FCd_a;\
        		FClnb     	= ln(1.0+latb*FCw);\
            		FClnl     	= ln(1.0+latl*FCw);\
            		FCa1      	= FClnb - FClnl;\
            		FCda1_dw 	= latb/(1.0+latb*FCw) - latl/(1.0+latl*FCw);\
		end else begin\
        		FCf1		= 1.0-FCa_ck;\
        		FCd_a		= 1.0/(1.0-FCf1*latb);\
			FCw		= FCf1*FCd_a;\
        		FCa		= FCz*FCw;\
        		FCdw_daick	= -1.0*FCd_a*FCd_a;\
            		FClnb     	= latb*FCw;\
            		FClnl     	= latl*FCw;\
           		FCa1      	= FCz*FCw;\
            		FCda1_dw  	= FCz;\
		end\
        	FCf_CT		= 2.0/FCz;\
        	FCw2		= FCw*FCw;\
        	FCf1		= latb*latl*FCw*FCw2/3.0+(latb+latl)*FCw2/2.0+FCw;\
        	FCdf1_dw 	= latb*latl*FCw2 + (latb+latl)*FCw + 1.0;\
        	`HICFCI(latb,latl,FClnb,FCw,FCf2,FCdf2_dw)\
        	`HICFCI(latl,latb,FClnl,FCw,FCf3,FCdf3_dw)\
        	FCf_ci		= FCf_CT*(FCa*FCf1-FCf2+FCf3);\
        	FCdfc_dw	= FCf_CT*(FCa1*FCdf1_dw+FCda1_dw*FCf1-FCdf2_dw+FCdf3_dw);\
		FCdw_ditf	= FCdw_daick*FCdaick_ditf;\
		FCdfc_ditf	= FCdfc_dw*FCdw_ditf;\
        	`HICFCT(latb,FClnb,FCw,FCf2,FCdf2_dw)\
        	`HICFCT(latl,FClnl,FCw,FCf3,FCdf3_dw)\
		FCf_CT		= FCf_CT*(FCf2-FCf3);\
		FCdfCT_dw 	= FCf_CT*(FCdf2_dw-FCdf3_dw);\
		FCdfCT_ditf	= FCdfCT_dw*FCdw_ditf;\
	end else begin\
        	if(latb > 0.01) begin\
        		FCd_a		= 1.0/(1.0+FCa_ck*latb);\
        		FCw		= (1.0-FCa_ck)*FCd_a;\
        		FCdw_daick	= -(1.0+latb)*FCd_a*FCd_a;\
        	end else begin\
        		FCw		= 1.0-FCa_ck-FCa_ck*latb;\
        		FCdw_daick	= -(1.0+latb);\
        	end\
		FCw2		= FCw*FCw;\
        	FCz		= latb*FCw;\
        	FCz_1		= 1.0+FCz;\
        	FCd_f     	= 1.0/(FCz_1);\
        	FCf_ci		= FCw2*(1.0+FCz/3.0)*FCd_f;\
        	FCdfc_dw	= 2.0*FCw*(FCz_1+FCz*FCz/3.0)*FCd_f*FCd_f;\
		FCdw_ditf	= FCdw_daick*FCdaick_ditf;\
		FCdfc_ditf	= FCdfc_dw*FCdw_ditf;\
        	if (FCz > 0.001) begin\
            		FCf_CT    	= 2.0*(FCz_1*ln(FCz_1)-FCz)/(latb*latb*FCz_1);\
            		FCdfCT_dw 	= 2.0*FCw*FCd_f*FCd_f;\
       		end else begin\
            		FCf_CT    	= FCw2*(1.0-FCz/3.0)*FCd_f;\
            		FCdfCT_dw 	= 2.0*FCw*(1.0-FCz*FCz/3.0)*FCd_f*FCd_f;\
        	end\
		FCdfCT_ditf	= FCdfCT_dw*FCdw_ditf;\
     	end\
     	Q_CT	= Q_fC*FCf_CT;\
      	Q_fC	= Q_fC*FCf_ci;\
	T_fC	= FFT_pcS*(FCf_ci+Ix*FCdfc_ditf);\
	T_cT	= FFT_pcS*(FCf_CT+Ix*FCdfCT_ditf);

// TRANSIT-TIME AND STORED MINORITY CHARGE
// INPUT:
//  itf		: forward transport current
//  I_CK	: critical current
//  T_f		: transit time    \
//  Q_f		: minority charge / for low current
// IMPLICIT INPUT:
//  tef0, gtfe, fthc, thcs, alhc, latl, latb	: model parameters
// OUTPUT:
//  T_f		: transit time    \
//  Q_f		: minority charge / transient analysis
//  T_fT	: transit time    \
//  Q_fT	: minority charge / ICCR (transfer current)
//  Q_bf	: excess base charge
`define HICQFF(itf,I_CK,T_f,Q_f,T_fT,Q_fT)\
      if(itf < 1.0e-6*I_CK) begin\
        Q_fT		= Q_f;\
        T_fT		= T_f;\
      end else begin\
        FFa		= I_CK/itf;\
        FFd_TfE		= tef0_t*exp(-gtfe*ln(FFa));\
        FFd_QfE		= FFd_TfE*itf/(gtfe+1.0);\
        FFT_fbS		= (1.0-fthc)*thcs_t;\
        FFx		= 1.0-FFa;\
        FFs		= sqrt(FFx*FFx+alhc);\
        FFw		= (FFx+FFs)/(1.0+sqrt(1.0+alhc));\
        FFw_2		= FFw*FFw;\
        FFd_QfB		= FFT_fbS*itf*FFw_2;\
        FFa_w		= FFw_2*(1.0+2.0*FFa/FFs);\
        FFd_TfB		= FFT_fbS*FFa_w;\
        FFT_pcS		= fthc*thcs_t;\
        if(latb <= 0.0 && latl <= 0.0) begin\
          FFQ_fC	= FFT_pcS*itf*FFw_2;\
          FFT_fC	= FFT_pcS*FFa_w;\
          FFQ_cT	= FFQ_fC;\
          FFT_cT	= FFT_fC;\
        end else begin\
	  `HICQFC(itf,I_CK,FFT_pcS,FFQ_fC,FFQ_cT,FFT_fC,FFT_cT)\
	end\
        Q_f		= Q_f+FFd_QfB;\
        T_f		= T_f+FFd_TfB;\
        Q_fT		= Q_f+hfe*FFd_QfE+hfc*FFQ_cT;\
        T_fT		= T_f+hfe*FFd_TfE+hfc*FFT_cT;\
        Q_f		= Q_f+FFd_QfE+FFQ_fC;\
        T_f		= T_f+FFd_TfE+FFT_fC;\
      end

// IDEAL DIODE (WITHOUT CAPACITANCE):
// conductance calculation not required
// INPUT:
//  IS, IST	: saturation currents (model parameter related)
//  UM1		: ideality factor
//  U		: branch voltage
// IMPLICIT INPUT:
//  VT		: thermal voltage
// OUTPUT:
//  Iz		: diode current
`define HICDIO(IS,IST,UM1,U,Iz)\
	DIOY	= U/(UM1*VT);\
	if (IS > 0.0) begin\
		if (DIOY > `Dexp_lim) begin\
			le 	= (1 + (DIOY - `Dexp_lim));\
			DIOY	= `Dexp_lim;\
		end else begin\
			le	= 1;\
		end\
  		le 	= le*limexp(DIOY);\
		Iz	= IST*(le-1.0);\
		if(DIOY <= -14.0) begin\
			Iz	= -IST;\
		end\
	end else begin\
		Iz	= 0.0;\
        end

// CRITICAL CURRENT INDICATING ONSET OF HIGH CURRENT EFFECTS
// INPUT:
//  v_c		: unsmoothed effective collector voltage
//  Orci0_t	: reciprocal of low-field epi resistance
//  vlim_t 	: limitation voltage
//  Ovpt 	: reciprocal of punch-through voltage
// IMPLICIT INPUT:
//  VT		: thermal voltage
// OUTPUT:
//  I_CK  	: critical current
//  v_ceff	: smoothed effective collector voltage
`define HICICK(v_c,Orci0_t,vlim_t,Ovpt,I_CK,v_ceff)\
      ICKv	= v_c/VT;\
      if (ICKv < `ICKexp_lim) begin\
      		v_ceff	= (1.0+ln(1+exp(ICKv-1.0)))*VT;\
      end else begin\
      		v_ceff	= v_c;\
      end\
      ICKv	= v_ceff/vlim_t;\
      I_CK	= v_ceff*Orci0_t/sqrt(1.0+ICKv*ICKv);\
      ICKa	= (v_ceff-vlim_t)*Ovpt;\
      I_CK	= I_CK*(1.0+0.5*(ICKa+sqrt(ICKa*ICKa+1.0e-3)));

// SIMPLE AVALANCHE GENERATION CURRENT
// INPUT:
//  itf		: forward component of the transfer current
//  Ucap	: junction voltage
//  Cjci	: junction capacitance
// IMPLICIT INPUT:
//  cjci0_t,vdci_t,qavl_t,favl_t	: related to model parameters
// OUTPUT:
//  iavl	: current generated by avalanche effect
`define HICAVL(itf,Ucap,Cjci,iavl)\
      if(Ucap < 0.0 && favl_t > 0.0 && cjci0_t > 0.0) begin\
            AVLv_bord	= vdci_t-Ucap;\
            AVLv_q	= qavl_t/Cjci;\
            AVLU0	= qavl_t/cjci0_t;\
            if(AVLv_bord > AVLU0) begin\
              		AVLa	= favl_t*exp(-AVLv_q/AVLU0);\
              		AVLS_avl= AVLa*(AVLU0+(1.0+AVLv_q/AVLU0)*(AVLv_bord-AVLU0));\
            end else begin\
            		AVLS_avl	= favl_t*AVLv_bord*exp(-AVLv_q/AVLv_bord);\
            end\
            iavl	= itf*AVLS_avl;\
      end else begin\
      	    iavl	= 0.0;\
      end

// TUNNELING CURRENT FOR EMITTER-BASE BREAKDOWN
// INPUT:
//  mostly related to model parameters at different temperature
//  abx, aby		: bandgap voltages
//  Cp_t, Ci_t		: peripheral and intrinsic c-b junction cap at zero bias
//  Vp_t, Vi_t		: peripheral and intrinsic c-b built-in potential
//  Upp, Uii		: peripheral and intrinsic c-b junction voltages
//  Cpp, Cii		: peripheral and intrinsic c-b capacitances
// IMPLICIT INPUT:
//  tunode,cjep0,vdep,zep,cjei0,vdei,zei	: model parameters
// OUTPUT:
//  Itun	: current generated by tunneling effect
`define HICTUN(Cp_t,Vp_t,Upp,Cpp,Itun)\
	if(Upp < 0.0) begin\
		if(cjep0 > 0.0) begin\
			a_eg    = (vgb-2.55e-4*Tnom)/(vgb-2.55e-4*Tdev);\
			ab	= (Cp_t/cjep0)*sqrt(a_eg)*Vp_t*Vp_t/(vdep*vdep);\
			ibets_t	= ibets*ab;\
		end else begin\
			ibets_t	= ibets;\
		end\
		vve	= -Upp/Vp_t;\
		cce	= Cpp/Cp_t;\
		zex	= 1.0/zep;\
		pocce	= exp((1-zex)*ln(cce));\
		czz	= ibets_t*vve*pocce;\
		Itun	= czz*exp(-abet/pocce);\
	end else begin\
		Itun	= 0.0;\
	end

// TEMPERATURE UPDATE OF JUNCTION CAPACITANCE RELATED PARAMETERS
// INPUT:
//  mostly model parameters
//  x		: zero bias junction capacitance
//  y		: junction built-in potencial
//  z		: grading co-efficient
//  w		: ratio of maximum to zero-bias value of capacitance or punch-through voltage
//  is_al	: condition factor to check what "w" stands for
//  ww		: band-gap voltage
// IMPLICIT INPUT:
//  VT		: thermal voltage
//  vt0,qtt0,ln_qtt0,V_gT	: other model variables
// OUTPUT:
//  x_t		: temperature update of "x"
//  y_t		: temperature update of "y"
//  w_t		: temperature update of "w"

`define TMPHICJ(x,y,z,w,is_al,x_t,y_t,w_t)\
     if (x > 0.0) begin\
		vdj0	= y*qtt0-V_gT;\
		vdj1	= 0.1*y;\
		vdjt	= (vdj0-vdj1)/VT;\
		if (vdjt < `LN_EXP_LIMIT )\
			y_t	= vdj1+VT*ln(1.0+exp(vdjt));\
		else\
			y_t	= vdj0;\
		x_t	= x*exp(z*ln(y/y_t));\
		if (is_al == 1)\
			w_t	= w*y_t/y;\
		else\
			w_t	= w;\
    end else begin\
    		x_t	= x;\
    		y_t	= y;\
    		w_t	= w;\
    end

//INTERNAL BASE RESISTANCE DEPENDENT ON QP-CHANGE AND I_BI
// INPUT:
//  R_BI0, f_dqr0, F_GEO, f_qi	: model parameters at device temperature
//  Q_p0,  Q_jei, Q_f		: different charge components (section 2.1.6)
//  ibei			: diode current for internal b-e junction
// IMPLICIT INPUT:
//  VT		: thermal voltage
// OUTPUT:
//  R_BI	: charge and bias dependent internal base resistance
// Qjci is omitted to avoid any numerical problem
`define HICRBI(R_BI0,f_dqr0,F_GEO,f_qi,Q_p0,Q_jei,Q_f,ibei,R_BI)\
   if(R_BI0 > 0.0) begin\
      	f_QR	= (1+f_dqr0)*Q_p0;\
        Qz	= Q_jei+Q_f;\
	if(Q_f > 0.0) begin\
        	Q_fi	= Q_f*f_qi;\
        	f_p	= (Q_jei+Q_fi)/Qz;\
        end else begin\
        	f_p	= 1.0;\
        end\
        R_BI	= R_BI0*f_QR/(f_QR+Qz);\
        I_BI	= ibei;\
	if( I_BI >= 1.0e-20) begin\
      		ETA	= R_BI*I_BI*F_GEO/VT;\
      		if(ETA >= 1.0e-3) begin\
      			if(ETA < 0.02)\
        			R_BI	= R_BI*(1.0-0.5*ETA);\
      			else\
        			R_BI	= R_BI*ln(1.0+ETA)/ETA;\
      		end\
      	end\
      	R_BI	= R_BI*f_p;\
   end else begin\
   	R_BI	= 0.0;\
   end

module hicumL2p1 (c,b,e,s,tnode);

//Node definitions

inout 		c,b,e,s,tnode;
electrical 	c,b,e,s,ci,ei,bp,bi,si;
electrical 	tnode;

//Branch definitions
branch 		(b,bp) 	iresbx;
branch 		(b,bp) 	vresbx;
branch 		(ci,c) 	irescx;
branch 		(ci,c) 	vrescx;
branch 		(ei,e) 	iresex;
branch 		(ei,e) 	vresex;
branch 		(bp,bi) irescb;
branch 		(bp,bi) vrescb;
branch 		(si,s) 	irescs;
branch 		(si,s) 	vrescs;
branch		(tnode) br_sht;

// -- ###########################################################
// -- ###########     Parameters initialization  ################
// -- ###########################################################

//Transfer current
parameter real c10  	= 1.516E-31	from [0:1];
parameter real qp0  	= 5.939E-15	from (0:1];
parameter real ich  	= 1.0E11	from [0:inf); //`0' signifies infinity
parameter real hfe  	= 1.0		from [0:inf];
parameter real hfc  	= 0.03999	from [0:inf];
parameter real hjei 	= 0.435		from [0:100];
parameter real hjci 	= 0.09477	from [0:100];

//Base-Emitter diode currents
parameter real ibeis 	= 3.47E-20	from [0:1];
parameter real mbei  	= 1.025		from (0:10];
parameter real ireis 	= 390E-12	from [0:1];
parameter real mrei  	= 3		from (0:10];
parameter real ibeps 	= 4.18321E-21	from [0:1];
parameter real mbep  	= 1.045		from (0:10];
parameter real ireps 	= 1.02846E-14	from [0:1];
parameter real mrep  	= 3		from (0:10];
parameter real mcf  	= 1.0		from (0:10];

//Base-Collector diode currents
parameter real ibcis 	= 3.02613E-18	from [0:1.0];
parameter real mbci  	= 1.0		from (0:10];
parameter real ibcxs 	= 4.576E-29	from [0:1.0];
parameter real mbcx  	= 1.0		from (0:10];

//Base-Emitter tunneling current
parameter real ibets 	= 0.0		from [0:1];
parameter real abet  	= 36.74		from [0:inf);

//Base-Collector avalanche current
parameter real favl  	= 14.97		from [0:inf);
parameter real qavl  	= 7.2407E-14	from [0:inf);
parameter real alfav 	= 0.0;
parameter real alqav 	= 0.0;

//Series resistances
parameter real rbi0  	= 7.9		from [0:inf);
parameter real rbx   	= 13.15		from [0:inf);
parameter real fgeo  	= 0.724		from [0:1];
parameter real fdqr0 	= 200		from [0:1];
parameter real fcrbi 	= 0.0		from [0:1];
parameter real fqi   	= 1.0		from [0:1];
parameter real re    	= 9.77		from [0:inf);
parameter real rcx   	= 10		from [0:inf);

//Substrate transistor
parameter real itss 	= 2.81242E-19	from [0:1.0];
parameter real msf 	= 1.0		from (0:10];
parameter real iscs	= 7.6376E-17	from [0:1.0];
parameter real msc  	= 1.0		from (0:10];
parameter real tsf  	= 1.733E-8	from [0:inf);

//Intra-device substrate coupling
parameter real rsu 	= 800		from [0:inf);
parameter real csu 	= 1.778E-14	from [0:inf);

//Depletion Capacitances
parameter real cjei0 	= 5.24382E-14	from [0:inf);
parameter real vdei  	= 0.9956	from (0:10];
parameter real zei   	= 0.4		from (0:1];
parameter real aljei 	= 2.5		from [1:inf);
parameter real cjep0 	= 0		from [0:inf);
parameter real vdep  	= 1		from (0:10];
parameter real zep   	= 0.01		from (0:1];
parameter real aljep 	= 2.5		from [1:inf);
parameter real cjci0 	= 4.46887E-15	from [0:inf);
parameter real vdci  	= 0.7		from (0:10];
parameter real zci   	= 0.38		from (0:1];
parameter real vptci 	= 100		from (0:100];
parameter real cjcx0 	= 1.55709E-14	from [0:inf);
parameter real vdcx  	= 0.733		from (0:10];
parameter real zcx   	= 0.34		from (0:1];
parameter real vptcx 	= 100		from (0:100];
parameter real fbc   	= 0.3487	from [0:1];
parameter real cjs0  	= 17.68E-15	from [0:inf);
parameter real vds   	= 0.621625	from (0:10];
parameter real zs    	= 0.122136	from (0:1];
parameter real vpts  	= 1000		from (0:1000];

//Diffusion Capacitances
parameter real t0    	= 1.28E-12	from [0:inf);
parameter real dt0h 	= 260E-15	from [0:inf);
parameter real tbvl  	= 2.0E-13	from [0:inf);
parameter real tef0  	= 0.0		from [0:inf);
parameter real gtfe  	= 1.0		from (0:10];
parameter real thcs  	= 46E-15	from [0:inf);
parameter real alhc  	= 0.08913	from (0:10];
parameter real fthc  	= 0.8778	from [0:1];
parameter real rci0  	= 50.4277	from (0:inf);
parameter real vlim  	= 0.9		from (0:10];
parameter real vces  	= 0.01		from [0:1];
parameter real vpt   	= 10		from [0:100]; // `0' signifies large value (infinity)
parameter real tr	= 1.0E-11	from [0:inf);

//Isolation Capacitances
parameter real ceox 	= 1.71992E-15	from [0:inf);
parameter real ccox 	= 4.9E-15	from [0:inf);

//Non-quasi-static Effect
parameter real alqf 	= 0.1288	from [0:1];
parameter real alit 	= 1.0		from [0:1];

//Noise
parameter real kf 	= 2.83667E-9	from [0:inf);
parameter real af 	= 2.0		from (0:10];
parameter real krbi 	= 1.0       	from (0:inf);

//Lateral Geometry Scaling (at high current densities)
parameter real latb    	= 10.479	from [0:inf);
parameter real latl    	= 0.300012	from [0:inf);

//Temperature dependence
parameter real vgb     	= 1.112		from (0:10];
parameter real alt0    	= 0.0017580;
parameter real kt0     	= 4.07E-6;
parameter real zetaci  	= 0.7;
parameter real zetacx  	= 1.0;
parameter real alvs    	= 0.001;
parameter real alces   	= 0.000125;
parameter real zetarbi 	= 0.0;
parameter real zetarbx 	= 0.2;
parameter real zetarcx 	= 0.21;
parameter real zetare  	= 0.7;
parameter real alb     	= 0.007;

//Self-Heating
parameter real rth 	= 1293.95		from [0:inf);
parameter real cth 	= 7.22203E-11		from [0:inf);

//Circuit simulator specific parameters
parameter real tnom  	= 27.0;
parameter real dt    	= 0.0;			//dt in relation to 300K

	//Declaration of variables: begin

                //Temperature and drift
        real VT,Tamb,Tdev,Tnom,qtt0,qtt0_zci,ln_qtt0,r_VgVT,V_gT,dT,k;
	real ireis_t,ibeis_t,ibcxs_t,ibcis_t;
	real iscs_t,cje0_t,cjci0_t,cjcx0_t;
	real cjs0_t,rci0_t,vlim_t;
	real vces_t,thcs_t,tef0_t,rbi_t,rbi0_t;
	real rbx_t,rcx_t,re_t,rsu_t,t0_t;
	real vdei_t,vdci_t;
	real c10_t,cjei0_t,qp0_t;
      	real vdcx_t,vptcx_t,cjcx01_t,cjcx02_t,vpts_t,itss_t,tsf_t;
      	real ibeps_t,ireps_t,cjep0_t,ibets_t,abet_t;
      	real aljei_t,qavl_t,favl_t,vptci_t,vdep_t,aljep_t;

      	//Band-gap related
      	real mg,zetabci,zetabcxt,zetasct,zetatef,avs;
      	real k1,k2,k10,k20,vgbe0,vgbc0,vgsc0,dvg0;
      	real vgb0,vge0,vgc0,vgs0,vge_t0,vge_t,vgb_t,vgb_t0,vgbe_t,vgbe_t0,vt0;

        //Charge and capacitance for b-c junction
        real Qjci,Cjci,Qjcx,Qjcxi,Qjcii,qjcx0_t_i,ccox1,ccox2,C_1;
	real cjcx0_t_ii,cjcx0_t_i,qjcx0_t_ii,cratio_t,Cjcit,cc;

        //Charge and capacitance for b-e junction
        real Qjei,Cjei,vdj1,DFe;
        real Qjep,Cjep;

        //Transfer and base current, related charges and capacitances
        real itf,itr,it,ibei,irei,ibci,ibep,irep,ibh_rec;
	real Oich,Orci0_t,Ovpt,Otbhrec,Tf,Tr,VT_f,i_0f,i_0r,a_bpt,Q_0,Q_p,Q_bpt;
	real T_f0,Q_fT,Q_bf,T_fT,b_q,Q_fC,T_fC,T_cT,I_Tf1,A,a_h,vds_t;
      	real Q_pT,l_it,d_Q,d_Q0;
      	real cbepar1,cbepar2,qrbi;

        //Diffusion charge and critical current
        real Qf,Qdei,tf0;
        real Qr,Qdci;
        real ick;
        real vc,vceff;

	//Tunneling current
	real ibet;

        //Avalanche current
	real iavl;

	//Base resistance
        real rbi;

        //External b-c diode and cap
        real ijbcx,cjcx01,cjcx02;

        //Substrate diode and cap
        real ijsc,Cjs,Qjs;

        //Substrate Transistor
        real  HSUM,HSI_Tsu,HSa,HSb,Qdsu;

	//Self heating
	real pterm,itnode,qtnode;

	//Macro test
	real  ICKv,ICKa;	//HICICK
	real  AVLS_avl,AVLv_bord,AVLv_q,AVLU0,AVLa;//HICAVL
        real  vdj0,vdjt,vdt,d1; //TMPHICJ
	real  DIOY,le;//HICDIO
	real  FFT_fbS,FFa,FFx,FFs,FFw,FFw_2,FFd_QfB,FFd_TfB,FFT_pcS,FFQ_fC,FFT_fC,FFQ_cT,FFT_cT,FFd_TfE,FFd_QfE,FFa_w;//HICQFF
	real  FCz,FCw2,FCf1,FCf2,FCf3,FCf_ci,FCz_1;//HICQFC
	real  FCd_a,FCdaick_ditf,FCa,FCw,FCdw_daick,FCdfc_dw,FCdw_ditf,FCdfc_ditf,FCf_CT,FCdfCT_ditf,FCrt,FCln,FClnl,FClnb,FCda1_dw,FCdf1_dw,FCdf2_dw,FCdf3_dw,FCd_f;//HICQFC
	real  FCa1,FCa_ck,FCxl,FCxb;//HICQFC
	real  Dz_r,Dv_p,DV_f,DC_max,DC_c,Da,Dv_e,De,De_1,Dv_j1,Dv_r,De_2,Dv_j2,Dv_j4,DC_j1,DC_j2,DC_j3,DQ_j1,DQ_j2,DQ_j3,DCln1,DCln2,Dz1,Dzr1;//QCJMOD
	real  DFV_f,DFC_max,DFa,DFv_e,DFv_j,DFb,DFC_j1,DFQ_j,DFdvj_dv,DFs_q,DFs_q2;//QCJMODF
	real  z,a,a2,a3,r,x;//HICFCI
	real  FCdfCT_dw;
	real  f_QR,Qz,f_p,ETA,Q_fi,I_BI; //HICRBI
	real  a_eg,aa,ab,vve,cce,pocce,zex,czz; //HICTUN

	//Noise
  	real fourkt,twoq,flicker_Pwr,rbin;

	//Declaration of variables: end

//
//======================== Transistor model formulation ===================
//

analog	begin

	// Temperature and resulting parameter drift

	Tnom    = tnom+`P_CELSIUS0;
	Tamb    = $temperature;
	Tdev    = Tamb+dt+V(br_sht);

// Limit temperature to avoid FPE's in equations
	if(Tdev < `TMIN + 273.15)
	   Tdev = `TMIN + 273.15;
	else
 	if (Tdev > `TMAX + 273.15)
	   Tdev = `TMAX + 273.15;

//	vt0     = $vt(Tnom);
//	VT      = $vt(Tdev);
	vt0     = `P_K*Tnom /`P_Q;
	VT      = `P_K*Tdev /`P_Q;

	dT      = Tdev-Tnom;
	qtt0    = Tdev/Tnom;
	ln_qtt0 = ln(qtt0);
	avs     = alvs*Tnom;
        V_gT    = 3.0*VT*ln_qtt0 + vgb*(qtt0-1.0);
        r_VgVT  = V_gT/VT;

        //Temperature update: begin

        //Internal b-e diode saturation currents
        a	= mcf*r_VgVT/mbei - alb*dT;
	ibeis_t = ibeis*exp(a);
	a       = mcf*r_VgVT/mrei - alb*dT;
        ireis_t = ireis*exp(a);

        //Internal b-e junction capacitance
	`TMPHICJ(cjei0,vdei,zei,aljei,1,cjei0_t,vdei_t,aljei_t)

        //GICCR prefactor and zero bias hole charge
	c10_t	= c10*exp(r_VgVT);
	a	= vdei_t/vdei;
	qp0_t	= qp0*(1.0+0.5*zei*(1.0-a));

        // Low-field internal collector resistance
        qtt0_zci = exp(zetaci*ln_qtt0);
	Orci0_t	= 1.0/(rci0*qtt0_zci);

	//Voltage separating ohmic and saturation velocity regime
	a = vlim*qtt0_zci*(1.0-alvs*dT);
        k = (a-VT)/VT;
        if (k < `LN_EXP_LIMIT)
            vlim_t = VT + VT*ln(1.0+exp(k));
        else
            vlim_t = a;

        //Internal c-e saturation voltage
	vces_t  = vces*(1+alces*dT);

        //Internal b-c diode saturation current
        a       = r_VgVT/mbci;
        ibcis_t = ibcis*exp(a);

        //Internal b-c junction capacitance
        `TMPHICJ(cjci0,vdci,zci,vptci,0,cjci0_t,vdci_t,vptci_t)

        //Low-current forward transit time
	t0_t    = t0*(1+alt0*dT+kt0*dT*dT);

        //Neutral emitter storage time
        a      = 1.0+alb*dT;
        k      = 0.5*(a+sqrt(a*a+0.01));
        tef0_t = tef0*qtt0/k;

        //Saturation time constant at high current densities
	thcs_t  = thcs*qtt0_zci/qtt0;

	//Avalanche caurrent factors
	favl_t  = favl*exp(alfav*dT);
	qavl_t  = qavl*exp(alqav*dT);

        //Zero bias internal base resistance
	rbi0_t  = rbi0*exp(zetarbi*ln_qtt0);

	//Peripheral b-e diode saturation currents
	a       = mcf*r_VgVT/mbep - alb*dT;
        ibeps_t = ibeps*exp(a);
        a       = mcf*r_VgVT/mrep - alb*dT;
        ireps_t = ireps*exp(a);

	//Peripheral b-e junction capacitance
	`TMPHICJ(cjep0,vdep,zep,aljep,1,cjep0_t,vdep_t,aljep_t)

	//Temperature mapping for tunneling current is done inside HICTUN

	//Depletion capacitance splitting at b-c junction
	//Capacitances at peripheral and external base node
	 C_1	= (1.0-fbc)*(cjcx0+ccox);
	 if (C_1 >= ccox) begin
	 	ccox1	= ccox;
	 	ccox2	= 0;
	 	cjcx01	= C_1-ccox;
	 	cjcx02	= cjcx0-cjcx01;
	 end else begin
	 	ccox1 	= C_1;
	 	ccox2 	= ccox-ccox1;
	 	cjcx01	= 0.0;
	 	cjcx02	= cjcx0;
	 end

	`TMPHICJ(1.0,vdcx,zcx,vptcx,0,cratio_t,vdcx_t,vptcx_t)
	 cjcx01_t=cratio_t*cjcx01;
	 cjcx02_t=cratio_t*cjcx02;

	//External b-c diode saturation currents
	a       = r_VgVT/mbcx;
        ibcxs_t = ibcxs*exp(a);

	//Constant external series resistances
	rcx_t	= rcx*exp(zetarcx*ln_qtt0);
	rbx_t	= rbx*exp(zetarbx*ln_qtt0);
	re_t	= re*exp(zetare*ln_qtt0);

	//Forward transit time in substrate transistor
	tsf_t	= tsf*exp((zetacx-1.0)*ln_qtt0);

	//Saturation transfer current for substrate transistor
        a       = r_VgVT/msf;
        itss_t  = itss*exp(a);

	//Saturation current for c-s diode
        a       = r_VgVT*msc;
        iscs_t  = iscs*exp(a);

	//Capacitance for c-s junction
        `TMPHICJ(cjs0,vds,zs,vpts,0,cjs0_t,vds_t,vpts_t)

	//Temperature update:end

	//Model evaluation: begin

	//Intrinsic transistor
	//Internal base currents across b-e junction
	`HICDIO(ibeis,ibeis_t,mbei,V(bi,ei),ibei)
	`HICDIO(ireis,ireis_t,mrei,V(bi,ei),irei)

	//HICCR: begin

	//Avoid devide-by-zer and define infinity other way
	//High current correction for 2D and 3D effects
    	//if (ich > 0.0 && ich < inf)
	if (ich > 0.0 && ich < 10000)
       		Oich 	= 1.0/ich;
      	else
       		Oich	= 0.0;

	//Collector punch-through voltage
	//if(vpt > 0.0 && vpt < inf)
	if(vpt > 0.0 && vpt < 10000)
       		Ovpt	= 1.0/vpt;
     	else
       		Ovpt	= 0.0;

	//Initialization
	//Transfer current, minority charges and transit times
      	Tr	= tr;
      	VT_f	= mcf*VT;
      	i_0f	= c10_t * limexp(V(bi,ei)/VT_f);
      	i_0r	= c10_t * limexp(V(bi,ci)/VT);

	//Internal b-e and b-c junction capacitances and charges
	`QCJMODF(cjei0_t,vdei_t,zei,aljei_t,V(bi,ei),Cjei,Qjei)
	`HICJCAP(cjci0_t,vdci_t,zci,vptci_t,V(bi,ci),Cjci,Qjci)

	//Hole charge at low bias

      	Q_0	= qp0_t + hjei*Qjei + hjci*Qjci;
      	if(Q_0 < 0.6*qp0_t) begin
      		a_bpt	= 0.05;
      		Q_bpt	= a_bpt*qp0_t;
        	b_q	= Q_0/Q_bpt-1.0;
		Q_0	= Q_bpt*(1+ln(1+exp(b_q)));
	end

	//Transit time calculation at low current density
	`QCJMODF(cjci0_t,vdci_t,zci,2.4,V(bi,ci),Cjcit,d1)
	if(Cjcit > 0.0)
    		cc	= cjci0_t/Cjcit;
    	else
     		cc	= 1.0;
	T_f0	= t0_t+dt0h*(cc-1.0)+tbvl*(1/cc-1.0);

	//Effective collector voltage
      	vc	= V(ci,ei)-vces_t;

	//Critical current for onset of high-current effects
	`HICICK(vc,Orci0_t,vlim_t,Ovpt,ick,vceff)

	//Initial formulation of forward and reverse component of transfer current
	if (T_f0 > 0.0 || Tr > 0.0) begin
        	A	= 0.5*Q_0;
        	Q_p	= A+sqrt(A*A+T_f0*i_0f+Tr*i_0r);
      	end else begin
      		Q_p	= Q_0;
      	end

  	I_Tf1	=i_0f/Q_p;
      	a_h	= Oich*I_Tf1;
      	itf	= I_Tf1*(1.0+a_h);
      	itr	= i_0r/Q_p;

      	//Initial formulation of forward transit time, diffusion, GICCR and excess b-c charge
      	Tf	= T_f0;
      	Qf	= T_f0*itf;
	`HICQFF(itf,ick,Tf,Qf,T_fT,Q_fT)

	//Initial formulation of reverse diffusion charge
	Qr	= Tr*itr;

	//Preparation for iteration to get total hole charge and related variables
      	l_it	= 0;
      	if(Qf > `RTOLC*Q_p || a_h > `RTOLC) begin
		//Iteration for Q_pT requires improved initial solution
       		Qf	= sqrt(T_f0*itf*Q_fT);
        	Q_pT	= Q_0+Qf+Qr;
        	d_Q	= Q_pT;
		while (abs(d_Q) >= `RTOLC*abs(Q_pT) && l_it <= `l_itmax) begin
        		d_Q0	= d_Q;
        		I_Tf1	= i_0f/Q_pT;
        		a_h	= Oich*I_Tf1;
        		itf	= I_Tf1*(1.0+a_h);
        		itr	= i_0r/Q_pT;
        		Tf	= T_f0;
        		Qf	= T_f0*itf;
			`HICQFF(itf,ick,Tf,Qf,T_fT,Q_fT)
  			Qr	= Tr*itr;
        		if(Oich == 0.0)
        			a	= 1.0+(T_fT*itf+Qr)/Q_pT;
        		else
       				a	= 1.0+(T_fT*I_Tf1*(1.0+2.0*a_h)+Qr)/Q_pT;
        		d_Q	= -(Q_pT-(Q_0+Q_fT+Qr))/a;
			//Limit maximum change of Q_pT
        		a	= abs(0.3*Q_pT);
        		if(abs(d_Q) > a) begin
        			if (d_Q>=0)
        				d_Q	= a;
        			else
        				d_Q	= -a;
        		end
        		Q_pT	= Q_pT+d_Q;
        		l_it	= l_it+1;
		end //while

     		I_Tf1	= i_0f/Q_pT;
     		a_h	= Oich*I_Tf1;
      		itf	= I_Tf1*(1.0+a_h);
      		itr	= i_0r/Q_pT;

      		//Final transit times, charges and transport current components
      		Tf	= T_f0;
      		Qf	= T_f0*itf;
		`HICQFF(itf,ick,Tf,Qf,T_fT,Q_fT)
      		Qr	= Tr*itr;

	end //if

	//Currently no NQS effect implemented for Qf and itf

     	it	= itf-itr;

	//Diffusion charges for further use
      	Qdei	= Qf;
      	Qdci	= Qr;

	//High-frequency emitter current crowding (lateral NQS)
	//Currently not accurate: using ddx() operator may provide right formulation
 	qrbi	= fcrbi*(Qjei+Qdei+Qjci+Qdci);

	//HICCR: end

	//Internal base current across b-c junction
	`HICDIO(ibcis,ibcis_t,mbci,V(bi,ci),ibci)

	//Avalanche current
	`HICAVL(itf,V(bi,ci),Cjci,iavl)

	//Internal base resistance
	`HICRBI(rbi0_t,fdqr0,fgeo,fqi,qp0_t,Qjei,Qf,ibei,rbi)

	//Base currents across peripheral b-e junction
	`HICDIO(ibeps,ibeps_t,mbep,V(bp,ei),ibep)
	`HICDIO(ireps,ireps_t,mrep,V(bp,ei),irep)

	//Peripheral b-e junction capacitance and charge
	`QCJMODF(cjep0_t,vdep_t,zep,aljep_t,V(bp,ei),Cjep,Qjep)

	//Tunneling current
	//a_eg    = (vgb-2.55e-4*Tnom)/(vgb-2.55e-4*Tdev);
	`HICTUN(cjep0_t,vdep_t,V(bp,ei),Cjep,ibet)

	//Depletion capacitance and charge at peripheral b-c junction (bp,ci)
	`HICJCAP(cjcx02_t,vdcx_t,zcx,vptcx_t,V(bp,ci),cjcx0_t_ii,qjcx0_t_ii)

	//Base currents across peripheral b-c junction (bp,ci)
	`HICDIO(ibcxs,ibcxs_t,mbcx,V(bp,ci),ijbcx)

	//Depletion capacitance and charge at external b-c junction (b,ci)
	`HICJCAP(cjcx01_t,vdcx_t,zcx,vptcx_t,V(b,ci),cjcx0_t_i,qjcx0_t_i)

	//Depletion substrate capacitance and charge at s-c junction (si,ci)
	`HICJCAP(cjs0_t,vds_t,zs,vpts_t,V(si,ci),Cjs,Qjs)

	//Parasitic substrate transistor transfer current and diffusion charge
 	if(itss > 0.0) begin
 		HSUM	= msf*VT;
        	HSa	= limexp(V(bp,ci)/HSUM);
        	HSb	= limexp(V(si,ci)/HSUM);
        	HSI_Tsu	= itss_t*(HSa-HSb);
        	if(tsf > 0.0) begin
       	 		Qdsu	= tsf_t*itss_t*HSa;
      		end else begin
        		Qdsu	= 0.0;
       		end
      	end else begin
        	HSI_Tsu	= 0.0;
        	Qdsu	= 0.0;
      	end

	//Diode current for s-c junction (si,ci)
	`HICDIO(iscs,iscs_t,msc,V(si,ci),ijsc)

	//Self-heating calculation
	if (rth > 0.0) begin
		pterm	=  V(ci,ei)*it + (vdci_t-V(bi,ci))*iavl;
	end

	//Model evaluation: end

	//Define branch sources: begin

	I(bp,ei) 	<+ -ibet+ibep+irep;
	I(bi,ei) 	<+ ibei+irei;
	I(bp,si) 	<+ HSI_Tsu;
	I(bp,ci) 	<+ ijbcx;
	I(bi,ci) 	<+ ibci-iavl;
	I(si,ci) 	<+ ijsc;
	I(ci,ei) 	<+ it;

   	I(b,ci)      	<+ ddt(ccox1*V(b,ci));
	I(bp,ci)        <+ ddt(ccox2*V(bp,ci));
	I(bp,e)  	<+ ddt(ceox*V(bp,e));

	I(si,ci)	<+ ddt(Qjs);
	I(bp,ei)	<+ ddt(Qjep);
	I(bi,ei) 	<+ ddt(Qdei+Qjei);
	I(bp,ci)	<+ ddt(qjcx0_t_ii+Qdsu);
	I(bi,ci)	<+ ddt(Qdci+Qjci);
	I(b,ci)		<+ ddt(qjcx0_t_i);

	if (rbx > 0.0) begin
		I(iresbx)	<+ V(iresbx)/rbx_t;
	end else begin
		V(vresbx) 	<+ 0.0;
	end
	if(rbi0 > 0.0) begin
		I(irescb)	<+ V(irescb)/rbi;
		I(irescb) 	<+ ddt(qrbi);
	end else begin
		V(vrescb) 	<+ 0.0;
	end
	if (rcx > 0.0) begin
		I(irescx)	<+ V(irescx)/rcx_t;
	end else begin
		V(vrescx)  	<+ 0.0;
	end
	if (re > 0.0) begin
		I(iresex)	<+ V(iresex)/re_t;
	end else begin
		V(vresex)  	<+ 0.0;
	end
	if(rsu > 0.0) begin
		I(irescs)  	<+ V(irescs)/rsu;
		I(irescs)	<+ ddt(csu*V(irescs));
	end else begin
		V(vrescs) 	<+ 0.0;
	end

//	if(rth > 0.0) begin
//		itnode		=  V(tnode)/rth-pterm;
//		I(tnode) 	<+ itnode;
//		I(tnode)	<+ ddt(V(tnode)*cth);
//	end else begin
//		V(tnode)	<+ 0.0;
//	end

	if(rth > 0.0) begin
		I(br_sht) 	<+ V(br_sht)/rth;
		I(br_sht)	<+ -pterm;
		I(br_sht) 	<+ ddt(cth*V(br_sht));
	end else begin
		V(br_sht)	<+ 0.0;

	end

	//Define branch source: end

	//Define noise sources: begin

	//Thermal noise
	fourkt 	= 4.0 * `P_K * Tdev;
	if(rbx > 0.0)
		I(iresbx)	<+ white_noise(fourkt/rbx_t,	"thermal");
	if(rbi0 > 0.0) begin
		rbin      	=  krbi * rbi;
		I(irescb) 	<+ white_noise(fourkt/rbin,	"thermal");
	end
	if(rcx > 0.0)
		I(irescx)	<+ white_noise(fourkt/rcx_t,	"thermal");
	if(re > 0.0)
		I(iresex)	<+ white_noise(fourkt/re_t,	"thermal");
	if(rsu > 0.0)
		I(irescs)	<+ white_noise(fourkt/rsu,	"thermal");

	//Flicker noise
   	flicker_Pwr  	= kf*pow((ibei+ibep),af);
   	I(bi,ei) 	<+ flicker_noise(flicker_Pwr,1.0);

   	//Shot noise
   	twoq	= 2.0 * `P_Q;
   	I(ci,ei) 	<+ white_noise(twoq*it,		"shot");
  	I(ci,bi) 	<+ white_noise(twoq*iavl,	"shot");
 	I(bi,ei) 	<+ white_noise(twoq*ibei,	"shot");
  	I(bi,ci) 	<+ white_noise(twoq*ibci,	"shot");
	I(bp,ei) 	<+ white_noise(twoq*ibep,	"shot");
  	I(bp,ci) 	<+ white_noise(twoq*ijbcx,	"shot");
  	I(si,ci) 	<+ white_noise(twoq*ijsc,	"shot");

	//Correlated noise not yet implemented

	//Define noise sources: end

end //analog
endmodule
